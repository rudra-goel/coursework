ADE simulation setup
Run mode: Single Run, Sweeps and Corners
Tests:
  project_1_NAND2_FO1_INVERTER_1: project_1/NAND2_FO1_INVERTER/schematic, simulator spectre
