ADE simulation setup
Run mode: Single Run, Sweeps and Corners
Tests:
  project_1_InverterFO1_1: project_1/InverterFO1/schematic, simulator spectre
