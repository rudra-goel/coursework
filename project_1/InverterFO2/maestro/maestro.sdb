ADE simulation setup
Run mode: Single Run, Sweeps and Corners
Tests:
  project_1_InverterFO2_1: project_1/InverterFO2/schematic, simulator spectre
