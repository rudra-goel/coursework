ADE simulation setup
Test project_1_InverterFO8_1: project_1/InverterFO8/schematic, simulator spectre
  Models: /nethome/rgoel68/ECE3150/ECE3150_Cadence/ECE3150_Cadence/FreePDK45/ncsu_basekit/models/hspice/tran_models/models_nom/NMOS_THKOX.inc, /nethome/rgoel68/ECE3150/ECE3150_Cadence/ECE3150_Cadence/FreePDK45/ncsu_basekit/models/hspice/tran_models/models_nom/NMOS_VTG.inc, /nethome/rgoel68/ECE3150/ECE3150_Cadence/ECE3150_Cadence/FreePDK45/ncsu_basekit/models/hspice/tran_models/models_nom/NMOS_VTH.inc, /nethome/rgoel68/ECE3150/ECE3150_Cadence/ECE3150_Cadence/FreePDK45/ncsu_basekit/models/hspice/tran_models/models_nom/NMOS_VTL.inc, /nethome/rgoel68/ECE3150/ECE3150_Cadence/ECE3150_Cadence/FreePDK45/ncsu_basekit/models/hspice/tran_models/models_nom/PMOS_THKOX.inc, /nethome/rgoel68/ECE3150/ECE3150_Cadence/ECE3150_Cadence/FreePDK45/ncsu_basekit/models/hspice/tran_models/models_nom/PMOS_VTG.inc, /nethome/rgoel68/ECE3150/ECE3150_Cadence/ECE3150_Cadence/FreePDK45/ncsu_basekit/models/hspice/tran_models/models_nom/PMOS_VTH.inc, /nethome/rgoel68/ECE3150/ECE3150_Cadence/ECE3150_Cadence/FreePDK45/ncsu_basekit/models/hspice/tran_models/models_nom/PMOS_VTL.inc
  Temperature: 27
  Stimulus In: voltage pulse val0=0 val1=1 period=2ns delay=10ps rise=10ps srcType=pulse
  Stimulus vdd!: voltage dc dc=1 srcType=dc
  Analysis tran: stop=10n
  Signals: /In, /net2
Run mode: Single Run, Sweeps and Corners
