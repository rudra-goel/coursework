ADE simulation setup
Run mode: Single Run, Sweeps and Corners
Tests:
  project_1_InverterFO8_1: project_1/InverterFO8/schematic, simulator spectre
