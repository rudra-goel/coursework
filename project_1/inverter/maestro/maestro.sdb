ADE simulation setup
Run mode: Single Run, Sweeps and Corners
Tests:
  project_1_inverter_1: project_1/inverter/schematic, simulator spectre
    Variables: Wp = 90n; Wn = 90n; Lp = 100n: 100n:500n; Ln = 50n
