ADE simulation setup
Run mode: Single Run, Sweeps and Corners
Tests:
  project_1_XOR2_1: project_1/XOR2/schematic, simulator spectre
