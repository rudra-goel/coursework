ADE simulation setup
Test project_3_full_adder_1_bit_1: project_3/full_adder_1_bit/schematic, simulator spectre
  Models: /nethome/rgoel68/ECE3150/ECE3150_Cadence/ECE3150_Cadence/FreePDK45/ncsu_basekit/models/hspice/tran_models/models_nom/NMOS_THKOX.inc, /nethome/rgoel68/ECE3150/ECE3150_Cadence/ECE3150_Cadence/FreePDK45/ncsu_basekit/models/hspice/tran_models/models_nom/NMOS_VTG.inc, /nethome/rgoel68/ECE3150/ECE3150_Cadence/ECE3150_Cadence/FreePDK45/ncsu_basekit/models/hspice/tran_models/models_nom/NMOS_VTH.inc, /nethome/rgoel68/ECE3150/ECE3150_Cadence/ECE3150_Cadence/FreePDK45/ncsu_basekit/models/hspice/tran_models/models_nom/NMOS_VTL.inc, /nethome/rgoel68/ECE3150/ECE3150_Cadence/ECE3150_Cadence/FreePDK45/ncsu_basekit/models/hspice/tran_models/models_nom/PMOS_THKOX.inc, /nethome/rgoel68/ECE3150/ECE3150_Cadence/ECE3150_Cadence/FreePDK45/ncsu_basekit/models/hspice/tran_models/models_nom/PMOS_VTG.inc, /nethome/rgoel68/ECE3150/ECE3150_Cadence/ECE3150_Cadence/FreePDK45/ncsu_basekit/models/hspice/tran_models/models_nom/PMOS_VTH.inc, /nethome/rgoel68/ECE3150/ECE3150_Cadence/ECE3150_Cadence/FreePDK45/ncsu_basekit/models/hspice/tran_models/models_nom/PMOS_VTL.inc
  Variables: Vdd = 1
  Temperature: 27
  Stimulus vdd!: voltage dc dc=Vdd srcType=dc
  Stimulus A: voltage pulse val0=0 val1=Vdd period=10n rise=10p fall=10p srcType=pulse
  Stimulus B: voltage pulse val0=0 val1=Vdd period=5n rise=10p fall=10p srcType=pulse
  Stimulus C_in: voltage pulse val0=0 val1=Vdd period=2.5n rise=10p fall=10p srcType=pulse
  Analysis tran: stop=20n
  Signals: /A, /B, /C_in, /S, /C_out
Run mode: Single Run, Sweeps and Corners
