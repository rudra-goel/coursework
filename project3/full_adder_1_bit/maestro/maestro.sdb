ADE simulation setup
Run mode: Single Run, Sweeps and Corners
Tests:
  project_3_full_adder_1_bit_1: project_3/full_adder_1_bit/schematic, simulator spectre
    Variables: Vdd = 1
