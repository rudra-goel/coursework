ADE simulation setup
Run mode: Single Run, Sweeps and Corners
Tests:
  project_3_Synchronous_16_bit_add_subtractor_1: project_3/Synchronous_16_bit_add_subtractor/schematic, simulator spectre
