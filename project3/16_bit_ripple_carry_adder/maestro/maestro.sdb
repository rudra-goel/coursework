ADE simulation setup
Run mode: Single Run, Sweeps and Corners
Tests:
  project_3_16_bit_ripple_carry_adder_1: project_3/16_bit_ripple_carry_adder/schematic, simulator spectre
