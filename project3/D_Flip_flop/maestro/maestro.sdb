ADE simulation setup
Run mode: Single Run, Sweeps and Corners
Tests:
  project_3_D_Flip_flop_1: project_3/D_Flip_flop/schematic, simulator spectre
