ADE simulation setup
Run mode: Single Run, Sweeps and Corners
Tests:
  project3_Synchronous_16_bit_add_subtractor_clk_buffer_1: project3/Synchronous_16_bit_add_subtractor_clk_buffer/schematic, simulator spectre
