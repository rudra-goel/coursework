ADE simulation setup
Test project3_inverter_vth_1: project3/inverter_vth/schematic, simulator spectre
  Models: /nethome/rgoel68/ECE3150/ECE3150_Cadence/ECE3150_Cadence/FreePDK45/ncsu_basekit/models/hspice/tran_models/models_nom/PMOS_VTL.inc, /nethome/rgoel68/ECE3150/ECE3150_Cadence/ECE3150_Cadence/FreePDK45/ncsu_basekit/models/hspice/tran_models/models_nom/PMOS_VTH.inc, /nethome/rgoel68/ECE3150/ECE3150_Cadence/ECE3150_Cadence/FreePDK45/ncsu_basekit/models/hspice/tran_models/models_nom/PMOS_VTG.inc, /nethome/rgoel68/ECE3150/ECE3150_Cadence/ECE3150_Cadence/FreePDK45/ncsu_basekit/models/hspice/tran_models/models_nom/PMOS_THKOX.inc, /nethome/rgoel68/ECE3150/ECE3150_Cadence/ECE3150_Cadence/FreePDK45/ncsu_basekit/models/hspice/tran_models/models_nom/NMOS_VTL.inc, /nethome/rgoel68/ECE3150/ECE3150_Cadence/ECE3150_Cadence/FreePDK45/ncsu_basekit/models/hspice/tran_models/models_nom/NMOS_VTH.inc, /nethome/rgoel68/ECE3150/ECE3150_Cadence/ECE3150_Cadence/FreePDK45/ncsu_basekit/models/hspice/tran_models/models_nom/NMOS_VTG.inc, /nethome/rgoel68/ECE3150/ECE3150_Cadence/ECE3150_Cadence/FreePDK45/ncsu_basekit/models/hspice/tran_models/models_nom/NMOS_THKOX.inc
  Temperature: 27
  Stimulus A: voltage dc dc=0 srcType=dc
  Stimulus vdd!: voltage dc dc=1 srcType=dc
  Analysis tran: stop=2n
  Signals: /A, /A~, /M1/D (terminal), /M0/D (terminal)
Run mode: Single Run, Sweeps and Corners
