ADE simulation setup
Run mode: Single Run, Sweeps and Corners
Tests:
  project3_inverter_vth_1: project3/inverter_vth/schematic, simulator spectre
