ADE simulation setup
Run mode: Single Run, Sweeps and Corners
Tests:
  project_3_16bit_2-1_mux_1: project_3/16bit_2-1_mux/schematic, simulator spectre
