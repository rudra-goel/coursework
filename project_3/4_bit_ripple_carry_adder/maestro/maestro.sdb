ADE simulation setup
Run mode: Single Run, Sweeps and Corners
Tests:
  project_3_4_bit_ripple_carry_adder_1: project_3/4_bit_ripple_carry_adder/schematic, simulator spectre
