ADE simulation setup
Test project_3_4_bit_ripple_carry_adder_1: project_3/4_bit_ripple_carry_adder/schematic, simulator spectre
  Models: /nethome/rgoel68/ECE3150/ECE3150_Cadence/ECE3150_Cadence/FreePDK45/ncsu_basekit/models/hspice/tran_models/models_nom/NMOS_THKOX.inc, /nethome/rgoel68/ECE3150/ECE3150_Cadence/ECE3150_Cadence/FreePDK45/ncsu_basekit/models/hspice/tran_models/models_nom/NMOS_VTG.inc, /nethome/rgoel68/ECE3150/ECE3150_Cadence/ECE3150_Cadence/FreePDK45/ncsu_basekit/models/hspice/tran_models/models_nom/NMOS_VTH.inc, /nethome/rgoel68/ECE3150/ECE3150_Cadence/ECE3150_Cadence/FreePDK45/ncsu_basekit/models/hspice/tran_models/models_nom/NMOS_VTL.inc, /nethome/rgoel68/ECE3150/ECE3150_Cadence/ECE3150_Cadence/FreePDK45/ncsu_basekit/models/hspice/tran_models/models_nom/PMOS_THKOX.inc, /nethome/rgoel68/ECE3150/ECE3150_Cadence/ECE3150_Cadence/FreePDK45/ncsu_basekit/models/hspice/tran_models/models_nom/PMOS_VTG.inc, /nethome/rgoel68/ECE3150/ECE3150_Cadence/ECE3150_Cadence/FreePDK45/ncsu_basekit/models/hspice/tran_models/models_nom/PMOS_VTH.inc, /nethome/rgoel68/ECE3150/ECE3150_Cadence/ECE3150_Cadence/FreePDK45/ncsu_basekit/models/hspice/tran_models/models_nom/PMOS_VTL.inc
  Temperature: 27
  Files: vectors /nethome/rgoel68/ECE3150/4b_RCA_tb.vec
  Stimulus vdd!: voltage dc dc=1 srcType=dc
  Analysis tran: stop=45n
  Signals: /A<3:0>, /B<3:0>, /C_in, /C_out, /Sout<3:0>
Run mode: Single Run, Sweeps and Corners
