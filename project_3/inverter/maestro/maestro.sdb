ADE simulation setup
Run mode: Single Run, Sweeps and Corners
Tests:
  project_1_inverter_1: project_1/inverter/schematic, simulator spectre
    Variables: vin = .5
