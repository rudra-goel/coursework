ADE simulation setup
Run mode: Single Run, Sweeps and Corners
Tests:
  project_1_NAND2_1: project_1/NAND2/schematic, simulator spectre
