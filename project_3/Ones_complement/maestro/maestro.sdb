ADE simulation setup
Run mode: Single Run, Sweeps and Corners
Tests:
  project_3_Twos_complement_1: project_3/Ones_complement/schematic, simulator spectre
