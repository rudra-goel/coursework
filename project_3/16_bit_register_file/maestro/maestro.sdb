ADE simulation setup
Run mode: Single Run, Sweeps and Corners
Tests:
  project_3_16_bit_register_file_1: project_3/16_bit_register_file/schematic, simulator spectre
