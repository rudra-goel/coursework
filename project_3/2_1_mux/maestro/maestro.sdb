ADE simulation setup
Run mode: Single Run, Sweeps and Corners
Tests:
  project_3_2_1_mux_1: project_3/2_1_mux/schematic, simulator spectre
