ADE simulation setup
Run mode: Single Run, Sweeps and Corners
Tests:
  project_3_Twos_Comp_Detector_1: project_3/Twos_Comp_Detector/schematic, simulator spectre
