ADE simulation setup
Test project_3_Twos_Comp_Detector_1: project_3/Twos_Comp_Detector/schematic, simulator spectre
  Models: /nethome/rgoel68/ECE3150/ECE3150_Cadence/ECE3150_Cadence/FreePDK45/ncsu_basekit/models/hspice/tran_models/models_nom/NMOS_THKOX.inc, /nethome/rgoel68/ECE3150/ECE3150_Cadence/ECE3150_Cadence/FreePDK45/ncsu_basekit/models/hspice/tran_models/models_nom/NMOS_VTG.inc, /nethome/rgoel68/ECE3150/ECE3150_Cadence/ECE3150_Cadence/FreePDK45/ncsu_basekit/models/hspice/tran_models/models_nom/NMOS_VTH.inc, /nethome/rgoel68/ECE3150/ECE3150_Cadence/ECE3150_Cadence/FreePDK45/ncsu_basekit/models/hspice/tran_models/models_nom/NMOS_VTL.inc, /nethome/rgoel68/ECE3150/ECE3150_Cadence/ECE3150_Cadence/FreePDK45/ncsu_basekit/models/hspice/tran_models/models_nom/PMOS_THKOX.inc, /nethome/rgoel68/ECE3150/ECE3150_Cadence/ECE3150_Cadence/FreePDK45/ncsu_basekit/models/hspice/tran_models/models_nom/PMOS_VTG.inc, /nethome/rgoel68/ECE3150/ECE3150_Cadence/ECE3150_Cadence/FreePDK45/ncsu_basekit/models/hspice/tran_models/models_nom/PMOS_VTH.inc, /nethome/rgoel68/ECE3150/ECE3150_Cadence/ECE3150_Cadence/FreePDK45/ncsu_basekit/models/hspice/tran_models/models_nom/PMOS_VTL.inc
  Temperature: 27
  Files: vectors /nethome/rgoel68/ECE3150/cout_detector_ckt_tb.vec
  Stimulus vdd!: voltage dc dc=1 srcType=dc
  Analysis tran: stop=10n
  Signals: /Cout, /Ctrl, /TwosComp
Run mode: Single Run, Sweeps and Corners
